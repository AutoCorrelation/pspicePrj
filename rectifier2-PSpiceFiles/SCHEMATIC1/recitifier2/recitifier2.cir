** Profile: "SCHEMATIC1-recitifier2"  [ c:\cadence\mjproj\rectifier2-pspicefiles\schematic1\recitifier2.sim ]

** Creating circuit file "recitifier2.cir"
** WARNING: THIS AUTOMATICALLY GENERATED FILE MAY BE OVERWRITTEN BY SUBSEQUENT SIMULATIONS

*Libraries:
* Profile Libraries :
* Local Libraries :
* From [PSPICE NETLIST] section of C:\Users\myhom\AppData\Roaming\SPB_Data\cdssetup\OrCAD_PSpice\17.2.0\PSpice.ini file:
.lib "nomd.lib"

*Analysis directives:
.TRAN  0 60ms 0 1us
.STEP PARAM Cvar LIST 10uF, 22uF, 33uF, 47uF, 56uF
.OPTIONS ADVCONV
.PROBE64 V(alias(*)) I(alias(*)) W(alias(*)) D(alias(*)) NOISE(alias(*))
.INC "..\SCHEMATIC1.net"

.END
