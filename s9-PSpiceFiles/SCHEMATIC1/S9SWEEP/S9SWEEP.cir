** Profile: "SCHEMATIC1-S9SWEEP"  [ c:\users\user\desktop\codespace\pspiceprj\s9-pspicefiles\schematic1\s9sweep.sim ]

** Creating circuit file "S9SWEEP.cir"
** WARNING: THIS AUTOMATICALLY GENERATED FILE MAY BE OVERWRITTEN BY SUBSEQUENT SIMULATIONS

*Libraries:
* Profile Libraries :
* Local Libraries :
* From [PSPICE NETLIST] section of C:\SPB_Data\cdssetup\OrCAD_PSpice\17.2.0\PSpice.ini file:
.lib "nomd.lib"

*Analysis directives:
.DC LIN V_VDS 0 5 0.02
+ LIN V_VGG 3.5 3.7 0.1
.OPTIONS ADVCONV
.PROBE64 V(alias(*)) I(alias(*)) W(alias(*)) D(alias(*)) NOISE(alias(*))
.INC "..\SCHEMATIC1.net"

.END
